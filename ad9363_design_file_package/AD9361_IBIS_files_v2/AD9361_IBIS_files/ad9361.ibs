|   ADI IBIS Modeling
[IBIS Ver]   5.1
[File Name]   ad9361.ibs
[File Rev]   2.0
[Date]   January 17, 2025
[Source]   Analog Devices, Inc.
[Notes]
[Disclaimer]
|   IBIS MODEL LICENSE AND DISCLAIMER AGREEMENT
|  Before downloading or using the below-referenced IBIS model, please read and
|  accept the license agreement and disclaimer shown below.
|   LICENSE STATEMENT
|  The information in this IBIS model is protected under the copyright laws of
|  the United States and other countries. Analog Devices, Inc. ("ADI") hereby
|  grants the users of this IBIS model (hereto referred to as licensee) a
|  nonexclusive, nontransferable license to use this IBIS model as long as the
|  licensee abides by the terms of this agreement.
|  Before using the IBIS model, the licensee should read this license. By using
|  , copying, modifying or redistributing this IBIS model,licensee accepts and
|  agrees to become bound by the terms of this agreement. If the licensee does
|  not accept these terms, then the licensee should not use the IBIS model and
|  should return it to ADI immediately.
|  The licensee may not sell, loan, rent, lease, distribute or license the IBIS
|  model,in whole, in part, or in modified form, to anyone outside the
|  licensee's company. The licensee may modify the IBIS model to suit his
|  specific applications, provided that all rights in such modifications and
|  derivative works shall belong to ADI. The licensee may make copies of this
|  IBIS model for use within his company only.
|  THIS IBIS MODEL IS PROVIDED AS IS, WHERE IS, AND WITH NO WARRANTY OF ANY
|  KIND EITHER EXPRESSED OR IMPLIED, INCLUDING BUT NOT LIMITED TO ANY IMPLIED
|  WARRANTIES OF MERCHANTABILITY AND FITNESS FOR A PARTICULAR PURPOSE.
|  Licensee understands that the mathematical behavioral characteristics and
|  formulas for the IBIS model have not been fully characterized for production
|  specification or exact compliance to actual part operation. The IBIS model
|  is useful for general simulations but not intended for safety critical,
|  manufacturing yield, or similar safety or financial decision making
|  simulations. IN NO EVENT SHALL THE ACCRUED TOTAL LIABILITY OF ANALOG DEVICES
|  , INC. FROM ANY LAWSUIT, CLAIM, WARRANTY OR INDEMNITY EXCEED One Hundred
|  Dollars ($100.00). In no event will ADI be liable for indirect, special,
|  collateral, incidental, consequential or punitive damages in connection with
|  or arising out of the use of this IBIS model. ADI reserves the right to
|  make changes to its products and the IBIS model without prior notice.
|  The Parties agree that the foregoing terms constitute the entire agreement
|  and that this agreement shall be governed by and construed in accordance
|  with the laws of the Commonwealth of Massachusetts and the United States,
|  without regard to choice of law provisions.
[Copyright]
|   This model is an exclusive property of Analog Devices Inc
|   and is not to be resold or redistributed without the written
|   permission of Analog Devices.
|   Copyright(c) 2021 Analog Devices, All Rights Reserved
[Component]  ad9361
[Manufacturer] Analog Devices, Inc.
[Package]
| variable   typ   min   max
R_pkg   179.07m   3.00m   575.63m
L_pkg   1.83n   0.03n   4.74n
C_pkg   0.91p   0.24p   23.40p
[Pin]  signal_name   model_name   R_pin   L_pin   C_pin
A1   RX2A_N   NC   4.344E-01   2.154E-09   9.910E-13
A2   RX2A_P   NC   4.120E-01   1.984E-09   1.010E-12
A3   NC   NC   3.254E-01   1.538E-09   7.445E-13
A4   VSSA   GND   3.233E-01   1.684E-09   1.069E-12
A5   TX_MON2   NC   4.159E-01   2.033E-09   9.820E-13
A6   VSSA   GND   NA   NA   NA
A7   TX2A_N   NC   2.898E+00   1.782E-09   1.274E-12
A8   TX2A_P   NC   2.880E-01   1.786E-09   1.333E-12
A9   TX2B_N   NC   3.211E-01   2.022E-09   1.857E-12
A10   TX2B_P   NC   3.182E-01   1.932E-09   1.582E-12
A11   VDDA1P1_TX_VCO   POWER   3.097E-01   1.711E-09   8.378E-13
A12   TX_EXT_LO_IN   NC   3.710E-01   2.135E-09   8.122E-13
B1   VSSA   GND   NA   NA   NA
B2   VSSA   GND   NA   NA   NA
B3   AUXDAC1   NC   3.058E-01   1.594E-09   8.778E-13
B4   GPO_3   out1   3.449E-01   1.678E-09   9.939E-13
B5   GPO_2   out1   3.144E-01   1.623E-09   9.464E-13
B6   GPO_1   out1   2.795E-01   1.405E-09   8.073E-13
B7   GPO_0   out1   2.991E-01   1.424E-09   8.333E-13
B8   VDD_GPO   POWER   2.569E-01   1.238E-09   7.650E-13
B9   VDDA1P3_TX_LO   POWER   2.268E-01   1.188E-09   6.322E-13
B10   VDDA1P3_TX_VCO_LDO   POWER   3.641E-01   1.841E-09   9.488E-13
B11   TX_VCO_LDO_OUT   POWER   3.699E-01   1.873E-09   7.868E-13
B12   VSSA   GND   NA   NA   NA
C1   RX2C_P   NC   3.650E-01   1.780E-09   6.628E-13
C2   VSSA   GND   NA   NA   NA
C3   AUXDAC2   NC   3.442E-01   1.795E-09   1.049E-12
C4   TEST/ENABLE   in1   2.970E-01   1.642E-09   9.649E-13
C5   CTRL_IN0   in1   4.738E-01   2.517E-09   1.110E-12
C6   CTRL_IN1   in1   4.520E-01   2.227E-09   1.239E-12
C7   VSSA   GND   NA   NA   NA
C8   VSSA   GND   NA   NA   NA
C9   VSSA   GND   NA   NA   NA
C10   VSSA   GND   NA   NA   NA
C11   VSSA   GND   NA   NA   NA
C12   VSSA   GND   NA   NA   NA
D1   RX2C_N   NC   3.628E-01   1.759E-09   6.552E-13
D2   VDDA1P3_RX_RF   POWER   NA   NA   NA
D3   VDDA1P3_RX_TX   POWER   NA   NA   NA
D4   CTRL_OUT0   out2   6.583E-01   4.131E-09   1.649E-12
D5   CTRL_IN3   in1   5.795E-01   3.200E-09   1.552E-12
D6   CTRL_IN2   in1   5.226E-01   3.310E-09   1.399E-12
D7   TX_D4_P   tx   4.405E-01   2.563E-09   1.601E-12
D8   TX_D3_P   tx   4.282E-01   2.302E-09   1.375E-12
D9   TX_D2_P   tx   3.284E-01   1.950E-09   1.020E-12
D10   TX_D1_P   tx   3.542E-01   1.984E-09   1.062E-12
D11   TX_D0_P   tx   3.348E-01   1.794E-09   9.171E-13
D12   VSSD   GND   NA   NA   NA
E1   RX2B_P   NC   3.258E-01   1.548E-09   6.347E-13
E2   VDDA1P3_RX_LO   POWER   2.739E-01   1.373E-09   9.105E-13
E3   VDDA1P3_TX_LO_BUFFER   POWER   NA   NA   NA
E4   CTRL_OUT1   out2   7.057E-01   4.192E-09   1.880E-12
E5   CTRL_OUT2   out2   5.320E-01   3.619E-09   1.661E-12
E6   CTRL_OUT3   out2   6.754E-01   4.038E-09   1.622E-12
E7   TX_D5_P   tx   3.838E-01   2.139E-09   1.277E-12
E8   TX_D4_N   tx   4.240E-01   2.569E-09   1.400E-12
E9   TX_D3_N   tx   4.115E-01   2.299E-09   1.416E-12
E10   TX_D2_N   tx   3.170E-01   1.906E-09   1.030E-12
E11   TX_D1_N   tx   3.591E-01   1.976E-09   1.063E-12
E12   TX_D0_N   tx   3.282E-01   1.742E-09   8.671E-13
F1   RX2B_N   NC   3.308E-01   1.584E-09   6.502E-13
F2   VDDA1P3_RX_VCO_LDO   POWER   2.934E-01   1.416E-09   6.265E-13
F3   VSSA   GND   NA   NA   NA
F4   CTRL_OUT6   out2   7.259E-01   4.403E-09   1.987E-12
F5   CTRL_OUT5   out2   4.427E-01   2.631E-09   1.465E-12
F6   CTRL_OUT4   out2   6.930E-01   4.497E-09   1.544E-12
F7   VSSD   GND   NA   NA   NA
F8   TX_D5_N   tx   3.660E-01   2.047E-09   1.199E-12
F9   VSSD   GND   NA   NA   NA
F10   FB_CLK_P   in2   2.276E-01   1.118E-09   6.672E-13
F11   VSSD   GND   NA   NA   NA
F12   VDDD1P3_DIG   POWER   4.599E-01   2.105E-09   1.237E-12
G1   RX_EXT_LO_IN   NC   3.079E-01   1.611E-09   6.318E-13
G2   RX_VCO_LDO_OUT   POWER   2.318E-01   1.151E-09   7.076E-13
G3   VDDA1P1_RX_VCO   POWER   2.429E-01   1.122E-09   7.052E-13
G4   CTRL_OUT7   out2   5.243E-01   3.162E-09   2.095E-12
G5   EN_AGC   in1   7.331E-01   4.437E-09   1.677E-12
G6   ENABLE   in1   5.257E-01   2.756E-09   1.453E-12
G7   RX_FRAME_N   out3   3.869E-01   2.104E-09   1.240E-12
G8   RX_FRAME_P   out3   3.882E-01   2.079E-09   1.323E-12
G9   TX_FRAME_P   in2   3.587E-01   1.925E-09   9.943E-13
G10   FB_CLK_N   in2   2.385E-01   1.162E-09   6.710E-13
G11   DATA_CLK_P   out3   3.364E-01   1.842E-09   1.012E-12
G12   VDD_INTERFACE   POWER   NA   NA   NA
H1   RX1B_P   NC   3.977E-01   1.906E-09   6.857E-13
H2   VSSA   GND   NA   NA   NA
H3   VSSA   GND   NA   NA   NA
H4   TXNRX   in1   7.474E-01   4.397E-09   1.965E-12
H5   SYNC_IN   in1   5.029E-01   3.008E-09   1.640E-12
H6   VSSA   GND   2.556E-01   1.246E-09   7.546E-13
H7   VSSD   GND   NA   NA   NA
H8   RX_D5_P   rx   3.010E-01   1.500E-09   9.301E-13
H9   TX_FRAME_N   in2   3.410E-01   1.804E-09   1.026E-12
H10   VSSD   GND   NA   NA   NA
H11   DATA_CLK_N   out3   3.235E-01   1.782E-09   1.125E-12
H12   VDD_INTERFACE   POWER   NA   NA   NA
J1   RX1B_N   NC   3.795E-01   1.848E-09   6.989E-13
J2   VSSA   GND   NA   NA   NA
J3   VDDA1P3_RX_SYNTH   POWER   4.407E-01   2.285E-09   1.148E-12
J4   SPI_DI   in1   4.632E-01   2.321E-09   1.189E-12
J5   SPI_CLK   in1   4.393E-01   2.111E-09   1.115E-12
J6   CLK_OUT   out2   4.472E-01   2.545E-09   1.207E-12
J7   RX_D5_N   rx   3.342E-01   1.737E-09   1.030E-12
J8   RX_D4_P   rx   3.366E-01   1.732E-09   9.630E-13
J9   RX_D3_P   rx   2.768E-01   1.335E-09   6.757E-13
J10   RX_D2_P   rx   2.987E-01   1.599E-09   1.023E-12
J11   RX_D1_P   rx   2.829E-01   1.379E-09   8.137E-13
J12   RX_D0_P   rx   2.997E-01   1.560E-09   7.776E-13
K1   RX1C_P   NC   4.533E-01   2.209E-09   8.878E-13
K2   VSSA   GND   NA   NA   NA
K3   VDDA1P3_TX_SYNTH   POWER   4.067E-01   2.233E-09   1.135E-12
K4   VDDA1P3_BB   POWER   NA   NA   NA
K5   RESETB   in1   6.730E-01   3.355E-09   1.865E-12
K6   SPI_ENB   in1   3.934E-01   1.865E-09   8.773E-13
K7   RX_D4_N   rx   3.558E-01   1.914E-09   1.087E-12
K8   RX_D3_N   rx   2.542E-01   1.206E-09   6.362E-13
K9   RX_D2_N   rx   2.865E-01   1.577E-09   7.972E-13
K10   RX_D1_N   rx   2.700E-01   1.327E-09   7.123E-13
K11   RX_D0_N   rx   2.994E-01   1.608E-09   9.406E-13
K12   VSSD   GND   NA   NA   NA
L1   RX1C_N   NC   4.489E-01   2.170E-09   9.134E-13
L2   VSSA   GND   NA   NA   NA
L3   VSSA   GND   NA   NA   NA
L4   RBIAS   NC   3.879E-01   1.986E-09   9.833E-13
L5   AUXADC   NC   3.547E-01   1.687E-09   8.423E-13
L6   SPI_DO   out2   3.451E-01   1.683E-09   8.162E-13
L7   VSSA   GND   NA   NA   NA
L8   VSSA   GND   NA   NA   NA
L9   VSSA   GND   NA   NA   NA
L10   VSSA   GND   NA   NA   NA
L11   VSSA   GND   NA   NA   NA
L12   VSSA   GND   NA   NA   NA
M1   RX1A_P   NC   4.267E-01   2.188E-09   1.053E-12
M2   RX1A_N   NC   4.025E-01   1.996E-09   8.743E-13
M3   NC   NC   3.087E-01   1.555E-09   9.134E-13
M4   VSSA   GND   4.126E-01   2.015E-09   9.897E-13
M5   TX_MON1   NC   3.971E-01   1.915E-09   1.034E-12
M6   VSSA   GND   NA   NA   NA
M7   TX1A_P   NC   3.049E-01   1.849E-09   1.360E-12
M8   TX1A_N   NC   2.982E-01   1.860E-09   1.533E-12
M9   TX1B_P   NC   3.416E-01   2.061E-09   1.772E-12
M10   TX1B_N   NC   3.342E-01   2.049E-09   1.859E-12
M11   XTALP   NC   5.787E-01   2.806E-09   1.375E-12
M12   XTALN   NC   5.594E-01   2.695E-09   1.360E-12
[Diff Pin] inv_pin   vdiff   tdelay_typ   tdelay_min   tdelay_max
| The '+' pin is Diff_pin and the '-' pin is the inv_pin
| Receiver Vth = +/-35mV
D7   E8   NA   NA   NA   NA
D8   E9   NA   NA   NA   NA
D9   E10   NA   NA   NA   NA
D10   E11   NA   NA   NA   NA
D11   E12   NA   NA   NA   NA
E7   F8   NA   NA   NA   NA
F10   G10   NA   NA   NA   NA
G8   G7   NA   NA   NA   NA
G9   H9   NA   NA   NA   NA
G11   H11   NA   NA   NA   NA
H8   J7   NA   NA   NA   NA
J8   K7   NA   NA   NA   NA
J9   K8   NA   NA   NA   NA
J10   K9   NA   NA   NA   NA
J11   K10   NA   NA   NA   NA
J12   K11   NA   NA   NA   NA
| Note: Comment Diff Pin when using Pin as CMOS
[Series Pin Mapping]   pin_2   model_name   function_table_group
D7   E8   TSP_Rterm
D8   E9   TSP_Rterm
D9   E10   TSP_Rterm
D10   E11   TSP_Rterm
D11   E12   TSP_Rterm
E7   F8   TSP_Rterm
F10   G10   TSP_Rterm
G9   H9   TSP_Rterm
[Model Selector]  in1
in1_1p5v   VDD=1.14-1.86V
in1_2p25v   VDD=2-2.625V
[Model Selector]  in2
in2_cmos_1p5v   VDD=1.14-1.86V
in2_cmos_2p25v   VDD=2.0-2.625V
in2_lvds_1p8v   VDD=1.71-1.89V
in2_lvds_2p25v   VDD=2.0-2.625V
[Model Selector]  out1
out1_1p8v   VDD=1.71-1.89V
out1_2p5v   VDD=2.2-2.7V
out1_3v   VDD=2.7-3.3v
[Model Selector]  out2
out2_1p5v_fdrv   VDD=1.14-1.86V Full-Drive Strength
out2_1p5v_hdrv   VDD=1.14-1.86V Half-Drive Strength
out2_2p25v_fdrv   VDD=2.0-2.625V Full-Drive Strength
out2_2p25v_hdrv   VDD=2.0-2.625V Half-Drive Strength
[Model Selector]  tx
tx_input_1p8v   LVDS_input_1.71-1.89V
tx_input_2p25v   LVDS_input_2.0-2.625V
tx_io2_1p5v_fdrv   CMOS_io_1.14-1.86V
tx_io2_1p5v_hdrv   CMOS_io_1.14-1.86V
tx_io2_2p25v_fdrv  CMOS_io_2.0-2.625V
tx_io2_2p25v_hdrv  CMOS_io_2.0-2.625V
[Model Selector]  rx
rx_io1_1p5v_fdrv   CMOS_VDD=1.14-1.86V Full-Drive Strength
rx_io1_1p5v_hdrv   CMOS_VDD=1.14-1.86V Half-Drive Strength
rx_io1_2p25v_fdrv   CMOS_VDD=2.0-2.625V Full-Drive Strength
rx_io1_2p25v_hdrv   CMOS_VDD=2.0-2.625V Half-Drive Strength
rx_out3_1p8v   LVDS_VDD=1.71-1.89V
rx_out3_2p25v   LVDS_VDD=2.0-2.625V
[Model Selector]  out3
out3_cmos_1p5v_fdrv   CMOS_VDD=1.14-1.86V Full-Drive Strength
out3_cmos_1p5v_hdrv   CMOS_VDD=1.14-1.86V Half-Drive Strength
out3_cmos_2p25v_fdrv   CMOS_VDD=2.0-2.625V Full-Drive Strength
out3_cmos_2p25v_hdrv   CMOS_VDD=2.0-2.625V Half-Drive Strength
out3_lvds_1p8v   LVDS_VDD=1.71-1.89V
out3_lvds_2p25v   LVDS_VDD=2.0-2.625V
[Define Package Model]  AD9361
[Manufacturer]   unknown
[OEM]   unknown
[Description]   unknown
[Number Of Pins]   106
[Pin Numbers]
L5 | 1 BGA1-L5 AUXADC
L4 | 2 BGA1-L4 RBIAS
K3 | 3 BGA1-K3 VDDA1P3_TX_SYNTH
K5 | 4 BGA1-K5 RESETB
J6 | 5 BGA1-J6 REF_CLK_OUT
J3 | 6 BGA1-J3 VDDA1P3_RX_SYNTH
M5 | 7 BGA1-M5 TX_MON1
M12 | 8 BGA1-M12 XTALN
M4 | 9 BGA1-M4 RX1_SA_LNA_IN
J5 | 10 BGA1-J5 SPI_CLK
B3 | 11 BGA1-B3 AUXDAC1
C3 | 12 BGA1-C3 AUXDAC2
B4 | 13 BGA1-B4 GPO_3
A4 | 14 BGA1-A4 RX2_SA_LNA_IN
C4 | 15 BGA1-C4 TEST/ENABLE
A5 | 16 BGA1-A5 TX_MON2
A3 | 17 BGA1-A3 RX2_SA_LNA_OUT
B7 | 18 BGA1-B7 GPO_0
A2 | 19 BGA1-A2 RX2A_P
A10 | 20 BGA1-A10 TX2B_P
B6 | 21 BGA1-B6 GPO_1
B5 | 22 BGA1-B5 GPO_2
C5 | 23 BGA1-C5 CTRL_IN0
C6 | 24 BGA1-C6 CTRL_IN1
B9 | 25 BGA1-B9 VDDA1P3_TX_LO
B8 | 26 BGA1-B8 VDDA_GPO
B11 | 27 BGA1-B11 TX_VCO_LDO_OUT
D6 | 28 BGA1-D6 CTRL_IN2
D5 | 29 BGA1-D5 CTRL_IN3
D4 | 30 BGA1-D4 CTRL_OUT0
E6 | 31 BGA1-E6 CTRL_OUT3
F4 | 32 BGA1-F4 CTRL_OUT6
E5 | 33 BGA1-E5 CTRL_OUT2
F6 | 34 BGA1-F6 CTRL_OUT4
E4 | 35 BGA1-E4 CTRL_OUT1
H4 | 36 BGA1-H4 TXNRX
D10 | 37 BGA1-D10 P0_D3-TX_D1_P
F5 | 38 BGA1-F5 CTRL_OUT5
G5 | 39 BGA1-G5 EN_AGC
B10 | 40 BGA1-B10 VDDA1P3_TX_VCO_LDO
G4 | 41 BGA1-G4 CTRL_OUT7
E7 | 42 BGA1-E7 P0_D11-TX_D5_P
H5 | 43 BGA1-H5 SYNC_IN
G8 | 44 BGA1-G8 RX_FRAME_P
G6 | 45 BGA1-G6 ENABLE
G3 | 46 BGA1-G3 VDDA1P1_RX_VCO
H11 | 47 BGA1-H11 DATA_CLK_N
G11 | 48 BGA1-G11 DATA_CLK_P
E8 | 49 BGA1-E8 P0_D8-TX_D4_N
F10 | 50 BGA1-F10 FB_CLK_P
E12 | 51 BGA1-E12 P0_D0-TX_D0_N
E11 | 52 BGA1-E11 P0_D2-TX_D1_N
E10 | 53 BGA1-E10 P0_D4-TX_D2_N
G10 | 54 BGA1-G10 FB_CLK_N
J12 | 55 BGA1-J12 P1_D1-RX_D0_P
H9 | 56 BGA1-H9 TX_FRAME_N
F12 | 57 BGA1-F12 VDDD1P3_DIG
G7 | 58 BGA1-G7 RX_FRAME_N
D8 | 59 BGA1-D8 P0_D7-TX_D3_P
G9 | 60 BGA1-G9 TX_FRAME_P
A8 | 61 BGA1-A8 TX2A_P
A7 | 62 BGA1-A7 TX2A_N
D11 | 63 BGA1-D11 P0_D1-TX_D0_P
F8 | 64 BGA1-F8 P0_D10_TX_D5_N
D7 | 65 BGA1-D7 P0_D9-TX_D4_P
J7 | 66 BGA1-J7 P1_D10_RX_D5_N
H6 | 67 BGA1-H6 REF_CLK_IN
D9 | 68 BGA1-D9 P0_D5-TX_D2_P
E9 | 69 BGA1-E9 P0_D6-TX_D3_N
K10 | 70 BGA1-K10 P1_D2-RX_D1_N
K11 | 71 BGA1-K11 P1_D0-RX_D0_N
J11 | 72 BGA1-J11 P1_D3-RX_D1_P
K9 | 73 BGA1-K9 P1_D4-RX_D2_N
H8 | 74 BGA1-H8 P1_D11_RX_D5_P
J8 | 75 BGA1-J8 P1_D9-RX_D4_P
K6 | 76 BGA1-K6 SPI_ENB
K7 | 77 BGA1-K7 P1_D8-RX_D4_N
K8 | 78 BGA1-K8 P1_D6-RX_D3_N
J10 | 79 BGA1-J10 P1_D5-RX_D2_P
J9 | 80 BGA1-J9 P1_D7-RX_D3_P
L6 | 81 BGA1-L6 SPI_DO
M3 | 82 BGA1-M3 RX1_SA_LNA_OUT
J4 | 83 BGA1-J4 SPI_DI
M11 | 84 BGA1-M11 XTALP
M10 | 85 BGA1-M10 TX1B_N
M2 | 86 BGA1-M2 RX1A_P
M7 | 87 BGA1-M7 TX1A_P
J1 | 88 BGA1-J1 RX1C_P
L1 | 89 BGA1-L1 RX1B_P
K1 | 90 BGA1-K1 RX1B_N
M1 | 91 BGA1-M1 RX1A_N
G2 | 92 BGA1-G2 RX_VCO_LDO_OUT
H1 | 93 BGA1-H1 RX1C_N
G1 | 94 BGA1-G1 RX_EXT_LO_IN
F2 | 95 BGA1-F2 VDDA1P3_RX_VCO_LDO
F1 | 96 BGA1-F1 RX2C_N
A1 | 97 BGA1-A1 RX2A_N
C1 | 98 BGA1-C1 RX2B_P
D1 | 99 BGA1-D1 RX2B_N
E1 | 100 BGA1-E1 RX2C_P
E2 | 101 BGA1-E2 VDDA1P3_RX_LO
M8 | 102 BGA1-M8 TX1A_N
M9 | 103 BGA1-M9 TX1B_P
A9 | 104 BGA1-A9 TX2B_N
A11 | 105 BGA1-A11 VDDA1P1_TX_VCO
A12 | 106 BGA1-A12 TX_EXT_LO_IN
[Model Data]
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[End Model Data]
[End Package Model]
|   Model R_ser_out_slvs_11V_100
[Model]   TSP_Rterm
Model_type   Series
C_comp   0  0  0
[Voltage Range]   2   1.71   2.625
[Temperature Range]   25.000   85.000   -40.0
[R series]   92   92   92
| Models and submodels in the file (32): TSP_Rterm (Series), in1_1p5v (Input), in1_2p25v (Input), in2_cmos_1p5v (Input), in2_cmos_2p25v (Input), in2_lvds_1p8v (Input), in2_lvds_2p25v (Input), out1_1p8v (3-state), out1_2p5v (3-state), out1_3v (3-state), out2_1p5v_fdrv (3-state), out2_1p5v_hdrv (3-state), out2_2p25v_fdrv (3-state), out2_2p25v_hdrv (3-state), tx_input_1p8v (Input), tx_input_2p25v (Input), tx_io2_1p5v_fdrv (I/O), tx_io2_1p5v_hdrv (I/O), tx_io2_2p25v_fdrv (I/O), tx_io2_2p25v_hdrv (I/O), rx_io1_1p5v_fdrv (I/O), rx_io1_1p5v_hdrv (I/O), rx_io1_2p25v_fdrv (I/O), rx_io1_2p25v_hdrv (I/O), rx_out3_2p25v (3-state), rx_out3_1p8v (3-state), out3_cmos_1p5v_fdrv (3-state), out3_cmos_1p5v_hdrv (3-state), out3_cmos_2p25v_fdrv (3-state), out3_cmos_2p25v_hdrv (3-state), out3_lvds_2p25v (3-state), out3_lvds_1p8v (3-state)
